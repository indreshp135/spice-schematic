* Sallen-Key low pass
.subckt OPAMP non_inv inv out vcc vee
E1 out 0 table {V(non_inv)-V(inv)} = (-15 -15) (15 15)
.ends
VCC vcc 0 DC 15
VEE vee 0 DC -15
VIN in 0 AC 1
R1 in n1 10k
R2 n1 n2 10k
C1 n1 out 10n
C2 n2 0 10n
X1 n2 out out vcc vee OPAMP
.control
ac dec 10 1 100k
plot 'Magnitude' vdb(out)
.endc
.end
